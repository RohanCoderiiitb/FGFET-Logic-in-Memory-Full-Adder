// =====================================================================
// cva_cap.va - voltage-dependent WL-to-memory-node coupling capacitance
// (C_VA in Fig. 1(c) of Kim et al., IEEE Access 2023).
//
// Generated by scripts/fit_cva.py; parameter defaults are the values
// calibrated against the Fig. 4 memory-node transients. Do not hand-edit:
// change the template and re-run the script instead.
//
// The WL metal wraps the polysilicon memory node across the VFET gate
// oxide, and the node surface accumulates or depletes depending on
// V(wl,mn), so C_VA has a depletion component (Fig. 3). It is modelled as a
// smooth tanh step between two levels around V(wl,mn) = Vfb:
//     C(v) = Cmin + (Cmax - Cmin)/2 * (1 + tanh((v - Vfb)/Vslp))
// i.e. Cmax applies for v >> Vfb and Cmin for v << Vfb. The replication
// guide assumed Cmax > Cmin; the Fig. 4 coupling ratios (~0.2 when WL is
// raised at initialize, 0.36-0.6 in storage/read) instead fit Cmax < Cmin.
//
// Charge is written in closed form and differentiated with ddt(), so the
// floating memory node conserves charge over any number of cycles.
// =====================================================================
`include "disciplines.vams"
`include "constants.vams"

module cva_cap (wl, mn);
    inout wl, mn;
    electrical wl, mn;

    parameter real Cmax = 8.50298e-17 from (0:inf);    // coupling for V(wl,mn) >> Vfb [F/um]
    parameter real Cmin = 1.81375e-15 from (0:inf);    // coupling for V(wl,mn) << Vfb [F/um]
    parameter real Vfb  = 0.339355 from (-5:5);      // centre of the C-V transition [V]
    parameter real Vslp = 0.0787248 from (0.01:5);   // width of the C-V transition [V]
    (*type="instance"*) parameter real W = 1.0 from (0:inf);   // device width [um]

    real v, x, lncosh, q;

    analog begin
        v = V(wl, mn);
        x = (v - Vfb) / Vslp;
        // ln(cosh(x)) written so it cannot overflow for large |x|
        lncosh = abs(x) + ln(1.0 + exp(-2.0 * abs(x))) - ln(2.0);
        // q = integral of C(v) dv, C(v) = Cmin + (Cmax-Cmin)/2 * (1 + tanh(x))
        q = W * (0.5 * (Cmax + Cmin) * v + 0.5 * (Cmax - Cmin) * Vslp * lncosh);
        I(wl, mn) <+ ddt(q);
    end
endmodule
