* =====================================================================
* FGFET equivalent subcircuit - Fig. 1(c) of Kim et al., IEEE Access 2023
* Generated by scripts/fit_cva.py
*
* Terminals
*   WL : word line   (VFET gate, top plate of C_VA)
*   DL : data line   (VFET drain)
*   SL : sense line  (SFET drain)
*   SS : SFET source (GND or the logic pull-down stack)
*   B  : substrate   (GND)
* Parameters
*   w_dev      : device width (VFET = SFET = C_VA width)
*   delvto_val : SFET threshold shift; 0 for A/C-type, 0.9 for B-type adders
*
* Usage (ngspice >= 39 with OSDI):
*   .control
*   pre_osdi <path>/cva_cap.osdi
*   .endc
*   .include <path>/fgfet_subckt.sp
*   X1 wl dl sl 0 0 FGFET w_dev=64n
*
* IMPORTANT: use `.options gmin=1e-15 chgtol=1e-18` (or tighter).
*  - ngspice's default gmin = 1e-12 S sits across the VFET source junction on
*    the floating memory node and discharges it within microseconds.
*  - the default chgtol = 1e-14 C exceeds the ~fC node charge, so the floating
*    node drifts by ~30 uV per WL cycle from integration error alone.
* =====================================================================
.include sfet_32nm.pm
.include vfet_32nm.pm

.model cva_fgfet cva_cap Cmax=5.74818e-17 Cmin=1.77441e-15 Vfb=0.318248 Vslp=0.0919169

.subckt FGFET WL DL SL SS B params: w_dev=64n delvto_val=0
* 1. vertical access FET: drain = DL, gate = WL, source = memory node MN
M_VFET DL WL MN B vfet_nmos L=100.2n W={w_dev}
* 2. sense FET: drain = SL, gate = MN, source = SS
M_SFET SL MN SS B sfet_nmos L=32n W={w_dev} delvto={delvto_val}
* 3. voltage-dependent WL-MN coupling capacitor (Verilog-A, width in um)
N_CVA WL MN cva_fgfet W={w_dev/1u}
* 4. 1000 TOhm DC path so the floating node has a defined operating point
R_conv MN 0 1000T
.ends FGFET
