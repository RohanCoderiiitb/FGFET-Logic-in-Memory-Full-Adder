* T5: 100 storage/read cycles after writing '1'
.include ../../models/fgfet_subckt.sp
VWL0 wl0 0 pwl(0 0 5e-09 0 1e-08 3 2.2e-06 3 2.205e-06 -2 2.3e-06 -2 2.305e-06 0.5 2.32e-06 0.5 2.325e-06 -2 2.34e-06 -2 2.345e-06 0.5 2.36e-06 0.5 2.365e-06 -2 2.38e-06 -2 2.385e-06 0.5 2.4e-06 0.5 2.405e-06 -2 2.42e-06 -2 2.425e-06 0.5 2.44e-06 0.5 2.445e-06 -2 2.46e-06 -2 2.465e-06 0.5 2.48e-06 0.5 2.485e-06 -2 2.5e-06 -2 2.505e-06 0.5 2.52e-06 0.5 2.525e-06 -2 2.54e-06 -2 2.545e-06 0.5 2.56e-06 0.5 2.565e-06 -2 2.58e-06 -2 2.585e-06 0.5 2.6e-06 0.5 2.605e-06 -2 2.62e-06 -2 2.625e-06 0.5 2.64e-06 0.5 2.645e-06 -2 2.66e-06 -2 2.665e-06 0.5 2.68e-06 0.5 2.685e-06 -2 2.7e-06 -2 2.705e-06 0.5 2.72e-06 0.5 2.725e-06 -2 2.74e-06 -2 2.745e-06 0.5 2.76e-06 0.5 2.765e-06 -2 2.78e-06 -2 2.785e-06 0.5 2.8e-06 0.5 2.805e-06 -2 2.82e-06 -2 2.825e-06 0.5 2.84e-06 0.5 2.845e-06 -2 2.86e-06 -2 2.865e-06 0.5 2.88e-06 0.5 2.885e-06 -2 2.9e-06 -2 2.905e-06 0.5 2.92e-06 0.5 2.925e-06 -2 2.94e-06 -2 2.945e-06 0.5 2.96e-06 0.5 2.965e-06 -2 2.98e-06 -2 2.985e-06 0.5 3e-06 0.5 3.005e-06 -2 3.02e-06 -2 3.025e-06 0.5 3.04e-06 0.5 3.045e-06 -2 3.06e-06 -2 3.065e-06 0.5 3.08e-06 0.5 3.085e-06 -2 3.1e-06 -2 3.105e-06 0.5 3.12e-06 0.5 3.125e-06 -2 3.14e-06 -2 3.145e-06 0.5 3.16e-06 0.5 3.165e-06 -2 3.18e-06 -2 3.185e-06 0.5 3.2e-06 0.5 3.205e-06 -2 3.22e-06 -2 3.225e-06 0.5 3.24e-06 0.5 3.245e-06 -2 3.26e-06 -2 3.265e-06 0.5 3.28e-06 0.5 3.285e-06 -2 3.3e-06 -2 3.305e-06 0.5 3.32e-06 0.5 3.325e-06 -2 3.34e-06 -2 3.345e-06 0.5 3.36e-06 0.5 3.365e-06 -2 3.38e-06 -2 3.385e-06 0.5 3.4e-06 0.5 3.405e-06 -2 3.42e-06 -2 3.425e-06 0.5 3.44e-06 0.5 3.445e-06 -2 3.46e-06 -2 3.465e-06 0.5 3.48e-06 0.5 3.485e-06 -2 3.5e-06 -2 3.505e-06 0.5 3.52e-06 0.5 3.525e-06 -2 3.54e-06 -2 3.545e-06 0.5 3.56e-06 0.5 3.565e-06 -2 3.58e-06 -2 3.585e-06 0.5 3.6e-06 0.5 3.605e-06 -2 3.62e-06 -2 3.625e-06 0.5 3.64e-06 0.5 3.645e-06 -2 3.66e-06 -2 3.665e-06 0.5 3.68e-06 0.5 3.685e-06 -2 3.7e-06 -2 3.705e-06 0.5 3.72e-06 0.5 3.725e-06 -2 3.74e-06 -2 3.745e-06 0.5 3.76e-06 0.5 3.765e-06 -2 3.78e-06 -2 3.785e-06 0.5 3.8e-06 0.5 3.805e-06 -2 3.82e-06 -2 3.825e-06 0.5 3.84e-06 0.5 3.845e-06 -2 3.86e-06 -2 3.865e-06 0.5 3.88e-06 0.5 3.885e-06 -2 3.9e-06 -2 3.905e-06 0.5 3.92e-06 0.5 3.925e-06 -2 3.94e-06 -2 3.945e-06 0.5 3.96e-06 0.5 3.965e-06 -2 3.98e-06 -2 3.985e-06 0.5 4e-06 0.5 4.005e-06 -2 4.02e-06 -2 4.025e-06 0.5 4.04e-06 0.5 4.045e-06 -2 4.06e-06 -2 4.065e-06 0.5 4.08e-06 0.5 4.085e-06 -2 4.1e-06 -2 4.105e-06 0.5 4.12e-06 0.5 4.125e-06 -2 4.14e-06 -2 4.145e-06 0.5 4.16e-06 0.5 4.165e-06 -2 4.18e-06 -2 4.185e-06 0.5 4.2e-06 0.5 4.205e-06 -2 4.22e-06 -2 4.225e-06 0.5 4.24e-06 0.5 4.245e-06 -2 4.26e-06 -2 4.265e-06 0.5 4.28e-06 0.5 4.285e-06 -2 4.3e-06 -2 4.305e-06 0.5 4.32e-06 0.5 4.325e-06 -2 4.34e-06 -2 4.345e-06 0.5 4.36e-06 0.5 4.365e-06 -2 4.38e-06 -2 4.385e-06 0.5 4.4e-06 0.5 4.405e-06 -2 4.42e-06 -2 4.425e-06 0.5 4.44e-06 0.5 4.445e-06 -2 4.46e-06 -2 4.465e-06 0.5 4.48e-06 0.5 4.485e-06 -2 4.5e-06 -2 4.505e-06 0.5 4.52e-06 0.5 4.525e-06 -2 4.54e-06 -2 4.545e-06 0.5 4.56e-06 0.5 4.565e-06 -2 4.58e-06 -2 4.585e-06 0.5 4.6e-06 0.5 4.605e-06 -2 4.62e-06 -2 4.625e-06 0.5 4.64e-06 0.5 4.645e-06 -2 4.66e-06 -2 4.665e-06 0.5 4.68e-06 0.5 4.685e-06 -2 4.7e-06 -2 4.705e-06 0.5 4.72e-06 0.5 4.725e-06 -2 4.74e-06 -2 4.745e-06 0.5 4.76e-06 0.5 4.765e-06 -2 4.78e-06 -2 4.785e-06 0.5 4.8e-06 0.5 4.805e-06 -2 4.82e-06 -2 4.825e-06 0.5 4.84e-06 0.5 4.845e-06 -2 4.86e-06 -2 4.865e-06 0.5 4.88e-06 0.5 4.885e-06 -2 4.9e-06 -2 4.905e-06 0.5 4.92e-06 0.5 4.925e-06 -2 4.94e-06 -2 4.945e-06 0.5 4.96e-06 0.5 4.965e-06 -2 4.98e-06 -2 4.985e-06 0.5 5e-06 0.5 5.005e-06 -2 5.02e-06 -2 5.025e-06 0.5 5.04e-06 0.5 5.045e-06 -2 5.06e-06 -2 5.065e-06 0.5 5.08e-06 0.5 5.085e-06 -2 5.1e-06 -2 5.105e-06 0.5 5.12e-06 0.5 5.125e-06 -2 5.14e-06 -2 5.145e-06 0.5 5.16e-06 0.5 5.165e-06 -2 5.18e-06 -2 5.185e-06 0.5 5.2e-06 0.5 5.205e-06 -2 5.22e-06 -2 5.225e-06 0.5 5.24e-06 0.5 5.245e-06 -2 5.26e-06 -2 5.265e-06 0.5 5.28e-06 0.5 5.285e-06 -2 5.3e-06 -2 5.305e-06 0.5 5.32e-06 0.5 5.325e-06 -2 5.34e-06 -2 5.345e-06 0.5 5.36e-06 0.5 5.365e-06 -2 5.38e-06 -2 5.385e-06 0.5 5.4e-06 0.5 5.405e-06 -2 5.42e-06 -2 5.425e-06 0.5 5.44e-06 0.5 5.445e-06 -2 5.46e-06 -2 5.465e-06 0.5 5.48e-06 0.5 5.485e-06 -2 5.5e-06 -2 5.505e-06 0.5 5.52e-06 0.5 5.525e-06 -2 5.54e-06 -2 5.545e-06 0.5 5.56e-06 0.5 5.565e-06 -2 5.58e-06 -2 5.585e-06 0.5 5.6e-06 0.5 5.605e-06 -2 5.62e-06 -2 5.625e-06 0.5 5.64e-06 0.5 5.645e-06 -2 5.66e-06 -2 5.665e-06 0.5 5.68e-06 0.5 5.685e-06 -2 5.7e-06 -2 5.705e-06 0.5 5.72e-06 0.5 5.725e-06 -2 5.74e-06 -2 5.745e-06 0.5 5.76e-06 0.5 5.765e-06 -2 5.78e-06 -2 5.785e-06 0.5 5.8e-06 0.5 5.805e-06 -2 5.82e-06 -2 5.825e-06 0.5 5.84e-06 0.5 5.845e-06 -2 5.86e-06 -2 5.865e-06 0.5 5.88e-06 0.5 5.885e-06 -2 5.9e-06 -2 5.905e-06 0.5 5.92e-06 0.5 5.925e-06 -2 5.94e-06 -2 5.945e-06 0.5 5.96e-06 0.5 5.965e-06 -2 5.98e-06 -2 5.985e-06 0.5 6e-06 0.5 6.005e-06 -2 6.02e-06 -2 6.025e-06 0.5 6.04e-06 0.5 6.045e-06 -2 6.06e-06 -2 6.065e-06 0.5 6.08e-06 0.5 6.085e-06 -2 6.1e-06 -2 6.105e-06 0.5 6.12e-06 0.5 6.125e-06 -2 6.14e-06 -2 6.145e-06 0.5 6.16e-06 0.5 6.165e-06 -2 6.18e-06 -2 6.185e-06 0.5 6.2e-06 0.5 6.205e-06 -2 6.22e-06 -2 6.225e-06 0.5 6.24e-06 0.5 6.245e-06 -2 6.26e-06 -2 6.265e-06 0.5 6.28e-06 0.5 6.285e-06 -2 6.35e-06 -2)
VDL0 dl0 0 pwl(0 0 1.1e-06 0 1.105e-06 1 2.2e-06 1 2.205e-06 0 6.35e-06 0)
VSL0 sl0 0 pwl(0 0 6.35e-06 0)
X0 wl0 dl0 sl0 0 0 FGFET w_dev=1u delvto_val=0
.options method=gear reltol=1e-4 gmin=1e-15 chgtol=1e-18
.control
pre_osdi ../../models/cva_cap.osdi
tran 0.5n 6.35e-06
set wr_singlescale
let isl0 = -i(vsl0)
wrdata ../results/t5_cycles.txt v(x0.mn) isl0
quit
.endc
.end
